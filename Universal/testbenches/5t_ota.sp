** Generated for: hspiceD
** Generated on: Feb 13 12:12:37 2026
** Design library name: MyProjects
** Design cell name: 5T_OTA_ADC_BW_UGF_GM_PM_CM
** Design view name: schematic
.LIB "/project/analog-group04/TSMC65GP_2f/models/hspice/crn65gplus_2d5_lk_v1d0.l" tt_bip
.LIB "/project/analog-group04/TSMC65GP_2f/models/hspice/crn65gplus_2d5_lk_v1d0.l" tt_dio
.LIB "/project/analog-group04/TSMC65GP_2f/models/hspice/crn65gplus_2d5_lk_v1d0.l" tt_dio_33
.LIB "/project/analog-group04/TSMC65GP_2f/models/hspice/crn65gplus_2d5_lk_v1d0.l" tt_mim
.LIB "/project/analog-group04/TSMC65GP_2f/models/hspice/crn65gplus_2d5_lk_v1d0.l" tt_dio_dnw
.LIB "/project/analog-group04/TSMC65GP_2f/models/hspice/crn65gplus_2d5_lk_v1d0.l" tt_dio_18
.LIB "/project/analog-group04/TSMC65GP_2f/models/hspice/crn65gplus_2d5_lk_v1d0.l" tt_bip_npn
.LIB "/project/analog-group04/TSMC65GP_2f/models/hspice/crn65gplus_2d5_lk_v1d0.l" tt_33
.LIB "/project/analog-group04/TSMC65GP_2f/models/hspice/crn65gplus_2d5_lk_v1d0.l" tt_rfrtmom
.LIB "/project/analog-group04/TSMC65GP_2f/models/hspice/crn65gplus_2d5_lk_v1d0.l" tt_mos_cap_25
.LIB "/project/analog-group04/TSMC65GP_2f/models/hspice/crn65gplus_2d5_lk_v1d0.l" tt_18
.LIB "/project/analog-group04/TSMC65GP_2f/models/hspice/crn65gplus_2d5_lk_v1d0.l" tt_disres
.LIB "/project/analog-group04/TSMC65GP_2f/models/hspice/crn65gplus_2d5_lk_v1d0.l" tt_res
.LIB "/project/analog-group04/TSMC65GP_2f/models/hspice/crn65gplus_2d5_lk_v1d0.l" tt_dio_na
.LIB "/project/analog-group04/TSMC65GP_2f/models/hspice/crn65gplus_2d5_lk_v1d0.l" tt_rfmos_33
.LIB "/project/analog-group04/TSMC65GP_2f/models/hspice/crn65gplus_2d5_lk_v1d0.l" tt_dio_hvt
.LIB "/project/analog-group04/TSMC65GP_2f/models/hspice/crn65gplus_2d5_lk_v1d0.l" tt_rfmvar
.LIB "/project/analog-group04/TSMC65GP_2f/models/hspice/crn65gplus_2d5_lk_v1d0.l" tt_rfmos_18
.LIB "/project/analog-group04/TSMC65GP_2f/models/hspice/crn65gplus_2d5_lk_v1d0.l" tt_na
.LIB "/project/analog-group04/TSMC65GP_2f/models/hspice/crn65gplus_2d5_lk_v1d0.l" tt_dio_na33
.LIB "/project/analog-group04/TSMC65GP_2f/models/hspice/crn65gplus_2d5_lk_v1d0.l" tt_dio_lvt
.LIB "/project/analog-group04/TSMC65GP_2f/models/hspice/crn65gplus_2d5_lk_v1d0.l" tt_rfres_sa
.LIB "/project/analog-group04/TSMC65GP_2f/models/hspice/crn65gplus_2d5_lk_v1d0.l" tt_na33
.LIB "/project/analog-group04/TSMC65GP_2f/models/hspice/crn65gplus_2d5_lk_v1d0.l" tt_dio_esd
.LIB "/project/analog-group04/TSMC65GP_2f/models/hspice/crn65gplus_2d5_lk_v1d0.l" tt_rfmim
.LIB "/project/analog-group04/TSMC65GP_2f/models/hspice/crn65gplus_2d5_lk_v1d0.l" tt_dio_25od33
.LIB "/project/analog-group04/TSMC65GP_2f/models/hspice/crn65gplus_2d5_lk_v1d0.l" tt_25od33
.LIB "/project/analog-group04/TSMC65GP_2f/models/hspice/crn65gplus_2d5_lk_v1d0.l" tt
.LIB "/project/analog-group04/TSMC65GP_2f/models/hspice/crn65gplus_2d5_lk_v1d0.l" tt_mos_cap
.LIB "/project/analog-group04/TSMC65GP_2f/models/hspice/crn65gplus_2d5_lk_v1d0.l" tt_dio_25
.LIB "/project/analog-group04/TSMC65GP_2f/models/hspice/crn65gplus_2d5_lk_v1d0.l" tt_dio_25ud18
.LIB "/project/analog-group04/TSMC65GP_2f/models/hspice/crn65gplus_2d5_lk_v1d0.l" tt_25
.LIB "/project/analog-group04/TSMC65GP_2f/models/hspice/crn65gplus_2d5_lk_v1d0.l" tt_rfmos
.LIB "/project/analog-group04/TSMC65GP_2f/models/hspice/crn65gplus_2d5_lk_v1d0.l" tt_25ud18
.LIB "/project/analog-group04/TSMC65GP_2f/models/hspice/crn65gplus_2d5_lk_v1d0.l" tt_dio_na25od33
.LIB "/project/analog-group04/TSMC65GP_2f/models/hspice/crn65gplus_2d5_lk_v1d0.l" tt_rfjvar
.LIB "/project/analog-group04/TSMC65GP_2f/models/hspice/crn65gplus_2d5_lk_v1d0.l" tt_rfmos_25
.LIB "/project/analog-group04/TSMC65GP_2f/models/hspice/crn65gplus_2d5_lk_v1d0.l" tt_rtmom
.LIB "/project/analog-group04/TSMC65GP_2f/models/hspice/crn65gplus_2d5_lk_v1d0.l" tt_na25od33
.LIB "/project/analog-group04/TSMC65GP_2f/models/hspice/crn65gplus_2d5_lk_v1d0.l" tt_dio_na25
.LIB "/project/analog-group04/TSMC65GP_2f/models/hspice/crn65gplus_2d5_lk_v1d0.l" tt_rfres_rpo
.LIB "/project/analog-group04/TSMC65GP_2f/models/hspice/crn65gplus_2d5_lk_v1d0.l" tt_hvt
.LIB "/project/analog-group04/TSMC65GP_2f/models/hspice/crn65gplus_2d5_lk_v1d0.l" tt_rfind
.LIB "/project/analog-group04/TSMC65GP_2f/models/hspice/crn65gplus_2d5_lk_v1d0.l" tt_rfmvar_25
.LIB "/project/analog-group04/TSMC65GP_2f/models/hspice/crn65gplus_2d5_lk_v1d0.l" tt_na25
.LIB "/project/analog-group04/TSMC65GP_2f/models/hspice/crn65gplus_2d5_lk_v1d0.l" tt_lvt

** Library name: MyProjects
** Cell name: 5T_OTA
** View name: schematic

.subckt DUT vp vn vout vdd vss ibias
m5 ibias ibias vss vss nch_lvt l=m5_l w='m5_w*1' m=1 nf=1 sd=200e-9 ad='((1-int(500e-3)*2)*175e-9+(2-int(1.0)*2)*100e-9)*m5_w' as='((1-int(500e-3)*2)*175e-9+(2-int(1.0)*2)*250e-9)*m5_w' pd='(1-int(500e-3)*2)*(350e-9+2*m5_w)+(2-int(1.0)*2)*(200e-9+1*m5_w)' ps='(1-int(500e-3)*2)*(350e-9+2*m5_w)+(2-int(1.0)*2)*(500e-9+3*m5_w)' nrd='(1-int(500e-3)*2)*(100e-9/m5_w)+(2-int(1.0)*2)*(100e-9/m5_w)' nrs='(1-int(500e-3)*2)*(100e-9/m5_w)+(2-int(1.0)*2)*(100e-9/m5_w)' sa=175e-9 sb=175e-9 sca=0 scb=0 scc=0
m4 net2 ibias vss vss nch_lvt l=m4_l w='m4_w*1' m=1 nf=1 sd=200e-9 ad='((1-int(500e-3)*2)*175e-9+(2-int(1.0)*2)*100e-9)*m4_w' as='((1-int(500e-3)*2)*175e-9+(2-int(1.0)*2)*250e-9)*m4_w' pd='(1-int(500e-3)*2)*(350e-9+2*m4_w)+(2-int(1.0)*2)*(200e-9+1*m4_w)' ps='(1-int(500e-3)*2)*(350e-9+2*m4_w)+(2-int(1.0)*2)*(500e-9+3*m4_w)' nrd='(1-int(500e-3)*2)*(100e-9/m4_w)+(2-int(1.0)*2)*(100e-9/m4_w)' nrs='(1-int(500e-3)*2)*(100e-9/m4_w)+(2-int(1.0)*2)*(100e-9/m4_w)' sa=175e-9 sb=175e-9 sca=0 scb=0 scc=0
m2 vout vn net2 net2 nch_lvt l=m2_l w='m2_w*1' m=1 nf=1 sd=200e-9 ad='((1-int(500e-3)*2)*175e-9+(2-int(1.0)*2)*100e-9)*m2_w' as='((1-int(500e-3)*2)*175e-9+(2-int(1.0)*2)*250e-9)*m2_w' pd='(1-int(500e-3)*2)*(350e-9+2*m2_w)+(2-int(1.0)*2)*(200e-9+1*m2_w)' ps='(1-int(500e-3)*2)*(350e-9+2*m2_w)+(2-int(1.0)*2)*(500e-9+3*m2_w)' nrd='(1-int(500e-3)*2)*(100e-9/m2_w)+(2-int(1.0)*2)*(100e-9/m2_w)' nrs='(1-int(500e-3)*2)*(100e-9/m2_w)+(2-int(1.0)*2)*(100e-9/m2_w)' sa=175e-9 sb=175e-9 sca=0 scb=0 scc=0
m0 net3 vp net2 net2 nch_lvt l=m0_l w='m0_w*1' m=1 nf=1 sd=200e-9 ad='((1-int(500e-3)*2)*175e-9+(2-int(1.0)*2)*100e-9)*m0_w' as='((1-int(500e-3)*2)*175e-9+(2-int(1.0)*2)*250e-9)*m0_w' pd='(1-int(500e-3)*2)*(350e-9+2*m0_w)+(2-int(1.0)*2)*(200e-9+1*m0_w)' ps='(1-int(500e-3)*2)*(350e-9+2*m0_w)+(2-int(1.0)*2)*(500e-9+3*m0_w)' nrd='(1-int(500e-3)*2)*(100e-9/m0_w)+(2-int(1.0)*2)*(100e-9/m0_w)' nrs='(1-int(500e-3)*2)*(100e-9/m0_w)+(2-int(1.0)*2)*(100e-9/m0_w)' sa=175e-9 sb=175e-9 sca=0 scb=0 scc=0
m3 vout net3 vdd vdd pch_lvt l=m3_l w='m3_w*1' m=1 nf=1 sd=200e-9 ad='((1-int(500e-3)*2)*175e-9+(2-int(1.0)*2)*100e-9)*m3_w' as='((1-int(500e-3)*2)*175e-9+(2-int(1.0)*2)*250e-9)*m3_w' pd='(1-int(500e-3)*2)*(350e-9+2*m3_w)+(2-int(1.0)*2)*(200e-9+1*m3_w)' ps='(1-int(500e-3)*2)*(350e-9+2*m3_w)+(2-int(1.0)*2)*(500e-9+3*m3_w)' nrd='(1-int(500e-3)*2)*(100e-9/m3_w)+(2-int(1.0)*2)*(100e-9/m3_w)' nrs='(1-int(500e-3)*2)*(100e-9/m3_w)+(2-int(1.0)*2)*(100e-9/m3_w)' sa=175e-9 sb=175e-9 sca=0 scb=0 scc=0
m1 net3 net3 vdd vdd pch_lvt l=m1_l w='m1_w*1' m=1 nf=1 sd=200e-9 ad='((1-int(500e-3)*2)*175e-9+(2-int(1.0)*2)*100e-9)*m1_w' as='((1-int(500e-3)*2)*175e-9+(2-int(1.0)*2)*250e-9)*m1_w' pd='(1-int(500e-3)*2)*(350e-9+2*m1_w)+(2-int(1.0)*2)*(200e-9+1*m1_w)' ps='(1-int(500e-3)*2)*(350e-9+2*m1_w)+(2-int(1.0)*2)*(500e-9+3*m1_w)' nrd='(1-int(500e-3)*2)*(100e-9/m1_w)+(2-int(1.0)*2)*(100e-9/m1_w)' nrs='(1-int(500e-3)*2)*(100e-9/m1_w)+(2-int(1.0)*2)*(100e-9/m1_w)' sa=175e-9 sb=175e-9 sca=0 scb=0 scc=0
.ends DUT
